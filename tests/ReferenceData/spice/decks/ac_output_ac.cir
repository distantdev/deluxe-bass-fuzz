* AC output_ac
.include "D:/HobbyCode/bass-fuzz-deluxe/tests/ReferenceData/spice/bmp_parts.lib"
Vcc vcc 0 DC 9
Vin in 0 DC 0 AC 1
X4 in c4 vcc BMP_Q4
C13 c4 out 100n
Rvol out 0 100k

.control
set wr_singlescale
set wr_vecnames
option numdgt=8
ac dec 50 20 20000
let mag_db = db(v(out))
let phase_deg = cph(v(out)) * 180 / pi
wrdata D:/HobbyCode/bass-fuzz-deluxe/tests/ReferenceData/spice/ac_output_ac.csv mag_db phase_deg
quit
.endc
.end
