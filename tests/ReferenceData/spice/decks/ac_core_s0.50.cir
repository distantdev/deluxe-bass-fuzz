* AC core_s0.50
.include "D:/HobbyCode/bass-fuzz-deluxe/tests/ReferenceData/spice/bmp_parts.lib"
Vcc vcc 0 DC 9
Vin in 0 DC 0 AC 1
X1 in c1 vcc BMP_Q1
Xs c1 sw BMP_SUSTAIN frac=0.0909091
X2 sw c2 vcc BMP_CLIP
X3 c2 c3 vcc BMP_CLIP
Xt c3 tw BMP_TONE tone=0.5
X4 tw c4 vcc BMP_Q4
C13 c4 out 100n
Rvol out 0 100k

.control
set wr_singlescale
set wr_vecnames
option numdgt=8
ac dec 50 20 20000
let mag_db = db(v(out))
let phase_deg = cph(v(out)) * 180 / pi
wrdata D:/HobbyCode/bass-fuzz-deluxe/tests/ReferenceData/spice/ac_core_s0.50.csv mag_db phase_deg
quit
.endc
.end
